.title KiCad schematic
.model __D1 D
.save all
.probe alli
.probe p(C2)
.probe p(C1)
.probe p(R1)
.probe p(R2)
.probe p(R3)
.probe p(D1)
.probe p(R5)
.probe p(R4)
D2 GND Net-_A1-D5_ LED
U3 __U3
A1 __A1
C2 Net-_A1-VIN_ GND 22u
C1 Net-_D1-K_ GND 47u
J1 __J1
U4 __U4
R1 Net-_U4-OUT1_ Net-_A1-D2_ 220
J3 __J3
R2 Net-_A1-D3_ Net-_U4-OUT2_ 220
R3 Net-_A1-D4_ Net-_U4-OUT3_ 220
K1 __K1
J2 __J2
D1 Net-_D1-A_ Net-_D1-K_ __D1
Q1 __Q1
R5 Net-_Q1-B_ Net-_R5-Pad2_ 1k
R4 Net-_R4-Pad1_ Net-_A1-D6_ 330
D3 GND Net-_D3-A_ LED
U2 __U2
.end
